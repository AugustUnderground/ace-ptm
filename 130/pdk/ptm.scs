//****************************************************************************
// Predictive Technology Models converted to Cadence Spectre Syntax
//
// Beta Version released on 2/22/06
//
// PTM 130nm NMOS
//
// Extracted from: http://ptm.asu.edu/latest.html
//  Specifically: http://ptm.asu.edu/modelcard/2006/130nm_bulk.pm
//
// Copyright 2005, Nanoscale Integration and Modeling (NIMO) Group,
// http://nimo.asu.edu/, ASU. All rights reserved.
//****************************************************************************

// PTM 130nm NMOS Model Card
model nmos bsim4 type = n

+version = 4.5       binunit = 1         paramchk= 1         mobmod  = 0
+capmod  = 2         igcmod  = 1         igbmod  = 1         geomod  = 1
+diomod  = 1         rdsmod  = 0         rbodymod= 1         rgatemod= 1
+permod  = 1         acnqsmod= 0         trnqsmod= 0

+tnom    = 27        toxe    = 2.25e-9   toxp    = 1.6e-9    toxm    = 2.25e-9
+dtox    = 0.65e-9   epsrox  = 3.9       wint    = 5e-009    lint    = 10.5e-009
+ll      = 0         wl      = 0         lln     = 1         wln     = 1
+lw      = 0         ww      = 0         lwn     = 1         wwn     = 1
+lwl     = 0         wwl     = 0         xpart   = 0         toxref  = 2.25e-9
+xl      = -60e-9
+vth0    = 0.3782    k1      = 0.4       k2      = 0.01      k3      = 0
+k3b     = 0         w0      = 2.5e-006  dvt0    = 1         dvt1    = 2
+dvt2    = -0.032    dvt0w   = 0         dvt1w   = 0         dvt2w   = 0
+dsub    = 0.1       minv    = 0.05      voffl   = 0         dvtp0   = 1.2e-010
+dvtp1   = 0.1       lpe0    = 0         lpeb    = 0         xj      = 3.92e-008
+ngate   = 2e+020    ndep    = 1.54e+018 nsd     = 2e+020    phin    = 0
+cdsc    = 0.0002    cdscb   = 0         cdscd   = 0         cit     = 0
+voff    = -0.13     nfactor = 1.5       eta0    = 0.0092    etab    = 0
+vfb     = -0.55     u0      = 0.05928   ua      = 6e-010    ub      = 1.2e-018
+uc      = 0         vsat    = 100370    a0      = 1         ags     = 1e-020
+a1      = 0         a2      = 1         b0      = 0         b1      = 0
+keta    = 0.04      dwg     = 0         dwb     = 0         pclm    = 0.06
+pdiblc1 = 0.001     pdiblc2 = 0.001     pdiblcb = -0.005    drout   = 0.5
+pvag    = 1e-020    delta   = 0.01      pscbe1  = 8.14e+008 pscbe2  = 1e-007
+fprout  = 0.2       pdits   = 0.08      pditsd  = 0.23      pditsl  = 2.3e+006
+rsh     = 5         rdsw    = 200       rsw     = 100       rdw     = 100
+rdswmin = 0         rdwmin  = 0         rswmin  = 0         prwg    = 0
+prwb    = 6.8e-011  wr      = 1         alpha0  = 0.074     alpha1  = 0.005
+beta0   = 30        agidl   = 0.0002    bgidl   = 2.1e+009  cgidl   = 0.0002
+egidl   = 0.8

+aigbacc = 0.012     bigbacc = 0.0028    cigbacc = 0.002
+nigbacc = 1         aigbinv = 0.014     bigbinv = 0.004     cigbinv = 0.004
+eigbinv = 1.1       nigbinv = 3         aigc    = 0.012     bigc    = 0.0028
+cigc    = 0.002     aigsd   = 0.012     bigsd   = 0.0028    cigsd   = 0.002
+nigc    = 1         poxedge = 1         pigcd   = 1         ntox    = 1

+xrcrg1  = 12        xrcrg2  = 5
+cgso    = 2.4e-010  cgdo    = 2.4e-010  cgbo    = 2.56e-011 cgdl    = 2.653e-10
+cgsl    = 2.653e-10 ckappas = 0.03      ckappad = 0.03      acde    = 1
+moin    = 15        noff    = 0.9       voffcv  = 0.02

+kt1     = -0.11     kt1l    = 0         kt2     = 0.022     ute     = -1.5
+ua1     = 4.31e-009 ub1     = 7.61e-018 uc1     = -5.6e-011 prt     = 0
+at      = 33000

+fnoimod = 1         tnoimod = 0

+jss     = 0.0001    jsws    = 1e-011    jswgs   = 1e-010    njs     = 1
+ijthsfwd= 0.01      ijthsrev= 0.001     bvs     = 10        xjbvs   = 1
+jsd     = 0.0001    jswd    = 1e-011    jswgd   = 1e-010    njd     = 1
+ijthdfwd= 0.01      ijthdrev= 0.001     bvd     = 10        xjbvd   = 1
+pbs     = 1         cjs     = 0.0005    mjs     = 0.5       pbsws   = 1
+cjsws   = 5e-010    mjsws   = 0.33      pbswgs  = 1         cjswgs  = 3e-010
+mjswgs  = 0.33      pbd     = 1         cjd     = 0.0005    mjd     = 0.5
+pbswd   = 1         cjswd   = 5e-010    mjswd   = 0.33      pbswgd  = 1
+cjswgd  = 5e-010    mjswgd  = 0.33      tpb     = 0.005     tcj     = 0.001
+tpbsw   = 0.005     tcjsw   = 0.001     tpbswg  = 0.005     tcjswg  = 0.001
+xtis    = 3         xtid    = 3

+dmcg    = 0e-006    dmci    = 0e-006    dmdg    = 0e-006    dmcgt   = 0e-007
+dwj     = 0.0e-008  xgw     = 0e-007    xgl     = 0e-008

+rshg    = 0.4       gbmin   = 1e-010    rbpb    = 5         rbpd    = 15
+rbps    = 15        rbdb    = 15        rbsb    = 15        ngcon   = 1

* PTM 130nm PMOS

// PTM 130nm PMOS Model Card
model pmos bsim4 type = p

+version = 4.5       binunit = 1         paramchk= 1         mobmod  = 0
+capmod  = 2         igcmod  = 1         igbmod  = 1         geomod  = 1
+diomod  = 1         rdsmod  = 0         rbodymod= 1         rgatemod= 1
+permod  = 1         acnqsmod= 0         trnqsmod= 0

+tnom    = 27        toxe    = 2.35e-009 toxp    = 1.6e-009  toxm    = 2.35e-009
+dtox    = 0.75e-9   epsrox  = 3.9       wint    = 5e-009    lint    = 10.5e-009
+ll      = 0         wl      = 0         lln     = 1         wln     = 1
+lw      = 0         ww      = 0         lwn     = 1         wwn     = 1
+lwl     = 0         wwl     = 0         xpart   = 0         toxref  = 2.35e-009
+xl      = -60e-9
+vth0    = -0.321    k1      = 0.4       k2      = -0.01     k3      = 0
+k3b     = 0         w0      = 2.5e-006  dvt0    = 1         dvt1    = 2
+dvt2    = -0.032    dvt0w   = 0         dvt1w   = 0         dvt2w   = 0
+dsub    = 0.1       minv    = 0.05      voffl   = 0         dvtp0   = 1e-009
+dvtp1   = 0.05      lpe0    = 0         lpeb    = 0         xj      = 3.92e-008
+ngate   = 2e+020    ndep    = 1.14e+018 nsd     = 2e+020    phin    = 0
+cdsc    = 0.000258  cdscb   = 0         cdscd   = 6.1e-008  cit     = 0
+voff    = -0.126    nfactor = 1.5       eta0    = 0.0092    etab    = 0
+vfb     = 0.55      u0      = 0.00835   ua      = 2.0e-009  ub      = 0.5e-018
+uc      = -3e-011   vsat    = 70000     a0      = 1.0       ags     = 1e-020
+a1      = 0         a2      = 1         b0      = -1e-020   b1      = 0
+keta    = -0.047    dwg     = 0         dwb     = 0         pclm    = 0.12
+pdiblc1 = 0.001     pdiblc2 = 0.001     pdiblcb = 3.4e-008  drout   = 0.56
+pvag    = 1e-020    delta   = 0.01      pscbe1  = 8.14e+008 pscbe2  = 9.58e-007
+fprout  = 0.2       pdits   = 0.08      pditsd  = 0.23      pditsl  = 2.3e+006
+rsh     = 5         rdsw    = 240       rsw     = 120       rdw     = 120
+rdswmin = 0         rdwmin  = 0         rswmin  = 0         prwg    = 3.22e-008
+prwb    = 6.8e-011  wr      = 1         alpha0  = 0.074     alpha1  = 0.005
+beta0   = 30        agidl   = 0.0002    bgidl   = 2.1e+009  cgidl   = 0.0002
+egidl   = 0.8

+aigbacc = 0.012     bigbacc = 0.0028    cigbacc = 0.002
+nigbacc = 1         aigbinv = 0.014     bigbinv = 0.004     cigbinv = 0.004
+eigbinv = 1.1       nigbinv = 3         aigc    = 0.69      bigc    = 0.0012
+cigc    = 0.0008    aigsd   = 0.0087    bigsd   = 0.0012    cigsd   = 0.0008
+nigc    = 1         poxedge = 1         pigcd   = 1         ntox    = 1

+xrcrg1  = 12        xrcrg2  = 5
+cgso    = 2.4e-010  cgdo    = 2.4e-010  cgbo    = 2.56e-011 cgdl    = 2.653e-10
+cgsl    = 2.653e-10 ckappas = 0.03      ckappad = 0.03      acde    = 1
+moin    = 15        noff    = 0.9       voffcv  = 0.02

+kt1     = -0.11     kt1l    = 0         kt2     = 0.022     ute     = -1.5
+ua1     = 4.31e-009 ub1     = 7.61e-018 uc1     = -5.6e-011 prt     = 0
+at      = 33000

+fnoimod = 1         tnoimod = 0

+jss     = 0.0001    jsws    = 1e-011    jswgs   = 1e-010    njs     = 1
+ijthsfwd= 0.01      ijthsrev= 0.001     bvs     = 10        xjbvs   = 1
+jsd     = 0.0001    jswd    = 1e-011    jswgd   = 1e-010    njd     = 1
+ijthdfwd= 0.01      ijthdrev= 0.001     bvd     = 10        xjbvd   = 1
+pbs     = 1         cjs     = 0.0005    mjs     = 0.5       pbsws   = 1
+cjsws   = 5e-010    mjsws   = 0.33      pbswgs  = 1         cjswgs  = 3e-010
+mjswgs  = 0.33      pbd     = 1         cjd     = 0.0005    mjd     = 0.5
+pbswd   = 1         cjswd   = 5e-010    mjswd   = 0.33      pbswgd  = 1
+cjswgd  = 5e-010    mjswgd  = 0.33      tpb     = 0.005     tcj     = 0.001
+tpbsw   = 0.005     tcjsw   = 0.001     tpbswg  = 0.005     tcjswg  = 0.001
+xtis    = 3         xtid    = 3

+dmcg    = 0e-006    dmci    = 0e-006    dmdg    = 0e-006    dmcgt   = 0e-007
+dwj     = 0.0e-008  xgw     = 0e-007    xgl     = 0e-008

+rshg    = 0.4       gbmin   = 1e-010    rbpb    = 5         rbpd    = 15
+rbps    = 15        rbdb    = 15        rbsb    = 15        ngcon   = 1

// Statistical Model
parameters Avt_nmos = 0 Au0_nmos = 0 Avt_pmos = 0 Au0_pmos = 0

statistics{
    process{ }
    mismatch{ vary Avt_nmos dist=gauss std=0.009
              vary Au0_nmos dist=gauss std=0.006
              vary Avt_pmos dist=gauss std=0.012
              vary Au0_pmos dist=gauss std=0.009
    }
}

// N-Channel MOSFET
subckt nfet (D G S B)
    parameters w=1e-6 l=130e-9
    m1 (D G S B) nmos w=w l=l ad=w*2e-12 as=w*2e-12 pd=w+4e-12 ps=w+4e-12 \
                      delvto=Avt_nmos/sqrt(w*l) \
                      mulu0=((0.05928+Au0_nmos/sqrt(w*l))/0.05928)
ends nfet

// P-Channel MOSFET
subckt pfet (D G S B)
    parameters w=1e-6 l=130e-9
    m1 (D G S B) pmos w=w l=l ad=w*2e-12 as=w*2e-12 pd=w+4e-12 ps=w+4e-12 \
                      delvto=Avt_nmos/sqrt(w*l) \
                      mulu0=((0.00835+Au0_nmos/sqrt(w*l))/0.00835)
ends pfet
