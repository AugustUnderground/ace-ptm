// characterization single-ended opamp 'op4' in PTM 130nm

simulator lang=spectre
global 0

include "ptm.scs"

parameters vs=500m vi=0 vsup=3.3 vcm=0 vo=0 vid=0 vicm=0                \
           a0=1 cl=5p fin=1k i0=3u rl=100M                              \
           Lcm1=1.95u Lcm2=3.35u  Lcm3=2.6u Ld=5.15u Lc1=1u   Lr=3.5u   \
           Wcm1=2.55u Wcm2=10.65u Wcm3=6.5u Wd=3u    Wc1=5.5u Wr=2u     \
           Mcm11=1    Mcm21=1     Mcm31=2   Md=2     Mc1=4              \
           Mcm12=1    Mcm22=4     Mcm32=2                               \
           Mcm13=2                                                      \
           A=(Mcm11+Mcm12)*Wcm1*Lcm1+2*Md*Wd*Ld+2*(Mcm21+Mcm22)*        \
             Wcm2*Lcm2+(Mcm31+Mcm32)*Wcm3*Lcm3 + Wr*Lr + 2*Wc1*Lc1*Mc1

subckt ideal_balun d c p n
    K0 (d 0 p c) transformer n1=2
    K1 (d 0 c n) transformer n1=2
ends ideal_balun

// Biasing
VSUPP (VDD CM) vsource dc=vsup/2 type=dc
VSUPN (CM VSS) vsource dc=vsup/2 type=dc
IREF  (VDD B)  isource dc=i0 type=dc
VCM (CM 0) vsource type=dc dc=0

//DUT
DUT (B INP INN OUT VDD VSS) op

OUTIDEAL (OUT_IDEAL 0  INP 0) vcvs gain=1/a0

INPSW (INP ICLPULSE ICLSIN INPOL) switch position=1
INNSW (INN FBB             INNOL) switch position=1
OUTSW (OF  OFL  OUT)              switch position=1

IPRB0 (FBA FBB) iprobe
FBNET (FBA CM  OUT CM) vcvs gain=a0

VIPULSE (ICLPULSE CM) vsource type=pulse dc=vid \
 val0=-vs/2 val1=vs/2 period=100u delay=5u rise=1n
VISIN   (ICLSIN   CM) vsource type=sine  ampl=a0 fa0req=fin

CL (OUT CM) capacitor c=cl
RL (OUT CM) resistor  r=rl

VO (OFI CM) vsource dc=vo type=dc
L2 (OFI OF) dcfeed l=1u
R2 (OFL  CM) resistor r=1M

BALUN (IND INCM INPOL INNOL) ideal_balun

VID  (IND  CM) vsource type=dc dc=vid mag=1
VICM (INCM CM) vsource type=dc dc=vicm

subckt op B INP INN O VDD VSS
    // Biasing current mirror
    MNCM11  (B  B   VSS VSS) nfet m=(Mcm11)*(1) w=Wcm1 l=Lcm1
    MNCM13  (CM B   VSS VSS) nfet m=(Mcm13)*(1) w=Wcm1 l=Lcm1
    MNCM12  (R  B   VSS VSS) nfet m=(Mcm12)*(1) w=Wcm1 l=Lcm1

    // NMOS Current mirror
    MNCM31  (Z  Z   VSS VSS) nfet m=(Mcm31)*(1) w=Wcm3 l=Lcm3
    MNCM32  (O  Z   VSS VSS) nfet m=(Mcm32)*(1) w=Wcm3 l=Lcm3

    // Differential Pair
    MND12   (X  INP CM  VSS) nfet m=(Md)*(1) w=Wd l=Ld
    MND11   (Y  INN CM  VSS) nfet m=(Md)*(1) w=Wd l=Ld

    // Cascode
    MPC1R   (R  R   VDD VDD) pfet m=(1)*(1) w=Wr  l=Lr
    MPC12   (Z  R   V   VDD) pfet m=Mc1*(1) w=Wc1 l=Lc1
    MPC11   (O  R   W   VDD) pfet m=Mc1*(1) w=Wc1 l=Lc1

    // PMOS Current mirror
    MPCM222 (V  Y   VDD VDD) pfet m=(Mcm22)*(1) w=Wcm2 l=Lcm2
    MPCM221 (Y  Y   VDD VDD) pfet m=(Mcm21)*(1) w=Wcm2 l=Lcm2
    MPCM212 (W  X   VDD VDD) pfet m=(Mcm22)*(1) w=Wcm2 l=Lcm2
    MPCM211 (X  X   VDD VDD) pfet m=(Mcm21)*(1) w=Wcm2 l=Lcm2
ends op

simulatorOptions options reltol=100e-6 vabstol=1e-6 \
    iabstol=1e-12 temp=27 tnom=27 homotopy=all gmin=1e-12 rforce=1 \
    save=selected dc_pivot_check=yes

save DUT.M*.m1:gm DUT.M*.m1:gds DUT.M*.m1:id DUT.M*.m1:gmoverid             \
     DUT.M*.m1:fug DUT.M*.m1:vdsat DUT.M*.m1:vgs DUT.M*.m1:vds              \
     DUT.M*.m1:vbs  DUT.M*.m1:gmb DUT.M*.m1:vth DUT.M*.m1:self_gain         \
     DUT.X DUT.Y DUT.Z DUT.B DUT.CM DUT:VDD DUT:VSS DUT:O DUT.R DUT.V DUT.W \
     OUT OUT_IDEAL INN INP VDD VSS OUT

fb1 alter dev=INPSW param=position value=1
fb2 alter dev=INNSW param=position value=1
fb3 alter dev=OUTSW param=position value=1
fb4 alter param=vid value=0
fb5 alter param=vo value=0
fb6 alter param=a0 value=1

dcop dc save=selected title="dcop"

dcmatch (OUT CM) dcmatch mth=0.9 method=statistics nsigma=1 \
    variations=mismatch where=rawfile prevoppoint=yes title="dcmatch"

stb stb start=1 stop=100G probe=IPRB0 localgnd=0 dec=50 title="stb"
tran tran stop=100u errpreset=conservative title="tran"

noise (OUT CM) noise start=1e-3 stop=1G iprobe=VIPULSE \
    separatenoise=no save=selected title="noise"

fb7 alter param=a0 value=0.1
dc1 dc param=vid start=-vsup*0.1 stop=vsup*0.1 lin=500 title="dc1"

ol1 alter dev=INNSW param=position value=2
ol2 alter dev=INPSW param=position value=3
ol3 alter dev=OUTSW param=position value=2

xf (OUT CM) xf  start=1e-3 stop=1G dec=50 title="xf" annotate=no
ac ac freq=1 param=vicm start=-vsup stop=vsup lin=1500 title="ac" annotate=no

ol41 alter param=vid value=vs/2
ol42 alter param=vo value=-vsup/2
dc3 dc title="dc3"

ol51 alter param=vid value=-vs/2
ol52 alter param=vo value=vsup/2
dc4 dc title="dc4"
