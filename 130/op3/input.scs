// characterization single-ended opamp 'op3' in PTM 130nm

simulator lang=spectre
global 0

include "ptm.scs"

parameters vs=100m vi=0 vsup=1.2 vcm=0 vo=0 vid=0 vicm=0 \
           a0=1 cl=5p fin=1k i0=3u rl=100M               \
           Lcm1=1.95u Lcm2=3.35u  Lcm3=2.6u Ld=5.15u     \
           Wcm1=2.55u Wcm2=10.65u Wcm3=6.5u Wd=3u        \
           Mcm11=1    Mcm2x1=1    Mcm31=1   Md=2         \
           Mcm12=2    Mcm212=4    Mcm32=2                \
                      Mcm222=2                           \
           A=(Mcm11+Mcm12)*Wcm1*Lcm1 + 2*Md*Wd*Ld +      \
             (2*Mcm2x1+Mcm212+Mcm222)*Wcm2*Lcm2 +        \
             (Mcm31+Mcm32)*Wcm3*Lcm3

subckt ideal_balun d c p n
    K0 (d 0 p c) transformer n1=2
    K1 (d 0 c n) transformer n1=2
ends ideal_balun

// Biasing
VSUPP (VDD CM) vsource dc=vsup/2 type=dc
VSUPN (CM VSS) vsource dc=vsup/2 type=dc
IREF  (VDD B)  isource dc=i0 type=dc
VCM (CM 0) vsource type=dc dc=0

//DUT
DUT (B INP INN OUT VDD VSS) op

OUTIDEAL (OUT_IDEAL 0  INP 0) vcvs gain=1/a0

INPSW (INP ICLPULSE ICLSIN INPOL) switch position=1
INNSW (INN FBB             INNOL) switch position=1
OUTSW (OF  OFL  OUT)              switch position=1

IPRB0 (FBA FBB) iprobe
FBNET (FBA CM  OUT CM) vcvs gain=a0

VIPULSE (ICLPULSE CM) vsource type=pulse dc=vid \
 val0=-vs/2 val1=vs/2 period=100u delay=5u rise=1n
VISIN   (ICLSIN   CM) vsource type=sine  ampl=a0 fa0req=fin

CL (OUT CM) capacitor c=cl
RL (OUT CM) resistor  r=rl

VO (OFI CM) vsource dc=vo type=dc
L2 (OFI OF) dcfeed l=1u
R2 (OFL  CM) resistor r=1M

BALUN (IND INCM INPOL INNOL) ideal_balun

VID  (IND  CM) vsource type=dc dc=vid mag=1
VICM (INCM CM) vsource type=dc dc=vicm

subckt op B INP INN O VDD VSS
  MNCM31 (Z Z VSS VSS) nmos m=(Mcm31)*(1) w=Wcm3 l=Lcm3 ad=0.7u*(Wcm3) \
          as=0.7u*(Wcm3) pd=0.7u*2+(Wcm3) ps=0.7u*2+(Wcm3) nrd=0.3u/(Wcm3) \
          nrs=0.3u/(Wcm3) par1=((Mcm31)*(1))
  MNCM32 (O Z VSS VSS) nmos m=(Mcm32)*(1) w=Wcm3 l=Lcm3 ad=0.7u*(Wcm3) \
          as=0.7u*(Wcm3) pd=0.7u*2+(Wcm3) ps=0.7u*2+(Wcm3) nrd=0.3u/(Wcm3) \
          nrs=0.3u/(Wcm3) par1=((Mcm32)*(1))
  MND12 (X INP CM VSS) nmos m=(Md)*(1) w=Wd l=Wd ad=0.7u*(Wd) as=0.7u*(Wd) \
          pd=0.7u*2+(Wd) ps=0.7u*2+(Wd) nrd=0.3u/(Wd) nrs=0.3u/(Wd) \
          par1=((Md)*(1))
  MND11 (Y INN CM VSS) nmos m=(Md)*(1) w=Wd l=Wd ad=0.7u*(Wd) as=0.7u*(Wd) \
          pd=0.7u*2+(Wd) ps=0.7u*2+(Wd) nrd=0.3u/(Wd) nrs=0.3u/(Wd) \
          par1=((Md)*(1))
  MNCM11 (B B VSS VSS) nmos m=(Mcm11)*(1) w=Wcm1 l=Lcm1 ad=0.7u*(Wcm1) \
          as=0.7u*(Wcm1) pd=0.7u*2+(Wcm1) ps=0.7u*2+(Wcm1) nrd=0.3u/(Wcm1) \
          nrs=0.3u/(Wcm1) par1=((Mcm11)*(1))
  MNCM12 (CM B VSS VSS) nmos m=(Mcm12)*(1) w=Wcm1 l=Lcm1 ad=0.7u*(Wcm1) \
          as=0.7u*(Wcm1) pd=0.7u*2+(Wcm1) ps=0.7u*2+(Wcm1) nrd=0.3u/(Wcm1) \
          nrs=0.3u/(Wcm1) par1=((Mcm12)*(1))
  MPCM222 (Z Y VDD VDD) pmos m=(Mcm222)*(1) w=Wcm2 l=Lcm2 ad=0.7u*(Wcm2) \
          as=0.7u*(Wcm2) pd=0.7u*2+(Wcm2) ps=0.7u*2+(Wcm2) nrd=0.3u/(Wcm2) \
          nrs=0.3u/(Wcm2) par1=((Mcm222)*(1))
  MPCM221 (Y Y VDD VDD) pmos m=(Mcm2x1)*(1) w=Wcm2 l=Lcm2 ad=0.7u*(Wcm2) \
          as=0.7u*(Wcm2) pd=0.7u*2+(Wcm2) ps=0.7u*2+(Wcm2) nrd=0.3u/(Wcm2) \
          nrs=0.3u/(Wcm2) par1=((Mcm2x1)*(1))
  MPCM212 (O X VDD VDD) pmos m=(Mcm212)*(1) w=Wcm2 l=Lcm2 ad=0.7u*(Wcm2) \
          as=0.7u*(Wcm2) pd=0.7u*2+(Wcm2) ps=0.7u*2+(Wcm2) nrd=0.3u/(Wcm2) \
          nrs=0.3u/(Wcm2) par1=((Mcm212)*(1))
  MPCM211 (X X VDD VDD) pmos m=(Mcm2x1)*(1) w=Wcm2 l=Lcm2 ad=0.7u*(Wcm2) \
          as=0.7u*(Wcm2) pd=0.7u*2+(Wcm2) ps=0.7u*2+(Wcm2) nrd=0.3u/(Wcm2) \
          nrs=0.3u/(Wcm2) par1=((Mcm2x1)*(1))
ends op

simulatorOptions options reltol=100e-6 vabstol=1e-6 \
    iabstol=1e-12 temp=27 tnom=27 homotopy=all gmin=1e-12 rforce=1 \
    save=selected dc_pivot_check=yes

save DUT.M*.m1:gm DUT.M*.m1:gds DUT.M*.m1:id DUT.M*.m1:gmoverid \
  DUT.M*.m1:fug DUT.M*.m1:vdsat DUT.M*.m1:vgs DUT.M*.m1:vds \
  DUT.M*.m1:vbs  DUT.M*.m1:gmb DUT.M*.m1:vth DUT.M*.m1:self_gain \
  DUT.X DUT.Y DUT.Z DUT.B DUT.CM DUT:VDD DUT:VSS VDD VSS OUT \
  DUT:O OUT OUT_IDEAL INN INP

fb1 alter dev=INPSW param=position value=1
fb2 alter dev=INNSW param=position value=1
fb3 alter dev=OUTSW param=position value=1
fb4 alter param=vid value=0
fb5 alter param=vo value=0
fb6 alter param=a0 value=1

dcop dc save=selected title="dcop"

dcmatch (OUT CM) dcmatch mth=0.9 method=statistics nsigma=1 \
  variations=mismatch where=rawfile prevoppoint=yes title="dcmatch"

stb stb start=1 stop=100G probe=IPRB0 localgnd=0 dec=50 title="stb"
tran tran stop=100u errpreset=conservative title="tran"

noise (OUT CM) noise start=1e-3 stop=1G iprobe=VIPULSE \
    separatenoise=no save=selected title="noise"

fb7 alter param=a0 value=0.1
dc1 dc param=vid start=-vsup*0.1 stop=vsup*0.1 lin=500 title="dc1"

ol1 alter dev=INNSW param=position value=2
ol2 alter dev=INPSW param=position value=3
ol3 alter dev=OUTSW param=position value=2

xf (OUT CM) xf  start=1e-3 stop=1G dec=50 title="xf" annotate=no
ac ac freq=1 param=vicm start=-vsup stop=vsup lin=1500 title="ac" annotate=no

ol41 alter param=vid value=vs/2
ol42 alter param=vo value=-vsup/2
dc3 dc title="dc3"

ol51 alter param=vid value=-vs/2
ol52 alter param=vo value=vsup/2
dc4 dc title="dc4"
